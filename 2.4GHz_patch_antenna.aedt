# Ansys Electronics Desktop project, version 2024.1
materials:
  vacuum: permittivity=1
  FR4_epoxy: permittivity=4.4 dielectric_loss_tangent=0.02
  pec: conductivity=1e+30

design HFSSDesign1 (HFSS, HFSS Modal Network, model units mm)
geometry:
  Rectangle1 = rectangle(corner=(15mm, 0mm, 0mm), x_size=70mm, y_size=100mm)
  Box1 [FR4_epoxy] = box(corner=(15mm, 0mm, 0mm), size=(70mm, 100mm, 1.6mm))
  Rectangle2 = rectangle(corner=(48mm, 0mm, 1.6mm), x_size=3.06mm, y_size=40.3mm)
  Rectangle3 = rectangle(corner=(30mm, 31mm, 1.6mm), x_size=38mm, y_size=29.5mm)
  SMA_RF_Jack1 = component(SMA_RF_Jack, 3D_Component_File_Path="<syslib>/3DComponents/HFSS/Surface Mount Devices/SMA_RF_Jack.a3dcomp", InnerStart=20mil, PinRadius=12mil, AntiPadDiameter=71mil, OuterRadius=81mil, PinLength=110mil, ConnectorHeight=300mil, InnerRadius=25mil, GroundRadius=105mil, AntiPadStep=5mil, GPinDepth=126mil, AuInner=0.1mil)
  Ground [brass] = part_of(SMA_RF_Jack1)
  Pin [copper] = part_of(SMA_RF_Jack1)
  Dielectric [Teflon (tm)] = part_of(SMA_RF_Jack1)
  SMA_RF_Jack1.rotate(RotateAxis=X RotateAngle=90deg)
  SMA_RF_Jack1.move(TranslateVectorX=49.5mm TranslateVectorY=-1mm TranslateVectorZ=1.9048mm)
  Box2 [pec] = box(corner=(44mm, 0mm, -0.5844mm), size=(8mm, 4mm, 0.5844mm))
  Circle1 = circle(normal=Y, centre=(49.5mm, -8.62mm, 1.9048mm), radius=0.63150614mm)
  Circle2 = circle(normal=Y, centre=(49.5mm, -8.62mm, 1.9048mm), radius=2.0574mm)
  Circle2.subtract(Circle1)
  Cylinder1 [pec] = cylinder(axis=Y, base_centre=(49.53mm, -8.62mm, 1.9048mm), radius=2.6771066mm, height=-0.75mm)
  Region [vacuum] = region(percentage_offset=500 on all sides)
  Rectangle4 = rectangle(corner=(46.47mm, 31mm, 1.6mm), x_size=6.12mm, y_size=7.5mm)
  Rectangle3.subtract(Rectangle4)
  Rectangle2.unite(Rectangle3)
boundaries and excitations:
  SMA_RF_Jack1_InnerAuPlate: Layered Impedance Faces=Pin.face(all 5) Frequency=0GHz Layers{Layer1{Thickness=0.1mil Material=SMA_RF_Jack1:gold} Layer2{LayerType=1 Thickness=1um Material=SMA_RF_Jack1:copper}}
  PerfE1: Perfect E Objects=Rectangle1
  PerfE2: Perfect E Objects=Rectangle2
  Rad1: Radiation Objects=Region
  1: Wave Port Objects=Circle2 WavePortType=Modal NumModes=1 Modes{Mode1{IntLine{(50.131506, -8.62, 1.9048) -> (51.5574, -8.62, 1.9048)} CharImp=Zpi RenormImp=50ohm}}
setups:
  Setup1: HfssDriven Frequency=2.4GHz MaxDeltaS=0.02 MaximumPasses=15 MinimumPasses=1 MinimumConvergedPasses=1 PercentRefinement=30 BasisOrder=1 PortAccuracy=2 DrivenSolverType="Direct Solver"
    sweep Sweep: 1.2GHz to 3.6GHz, 401 points; Type=Interpolating InterpTolerance=0.5 InterpMaxSolns=250 InterpUsePortImped=false PassivityErrorTolerance=0.0001
source amplitudes:
  1:1: 1W 0deg
reports:
  S Parameter Plot 1: dB(S(1,1)) vs Freq on Setup1 : Sweep; markers m1 at 2.31GHz, m2 at 2.508GHz, m3 at 2.4GHz
  S Parameter Chart 1: S(1,1) on Setup1 : Sweep [Freq=all]
  S Parameter Plot 2: dB(S(1,1)) vs Freq on Setup1 : Sweep
  S Parameter Chart 2: S(1,1) on Setup1 : Sweep [Freq=all]
  S Parameter Plot 3: dB(S(1,1)) vs Freq on Setup1 : Sweep; markers m1 at 2.286GHz, m2 at 2.514GHz, m3 at 2.316GHz, m4 at 2.472GHz
